** sch_path: /foss/designs/design_course/IC_Design_Course_DuTH/testcircuit/mos_parameter_extraction.sch
**.subckt mos_parameter_extraction
XM1 d_n g_n 0 b_n sky130_fd_pr__nfet_01v8 L=0.8 W=1 nf=1 ad=0.29 as=0.29 pd=2.58 ps=2.58 nrd=0.29 nrs=0.29 sa=0 sb=0 sd=0 mult=1
XM2 d_p g_p 0 b_p sky130_fd_pr__pfet_01v8 L=0.15 W=1 nf=1 ad=0.29 as=0.29 pd=2.58 ps=2.58 nrd=0.29 nrs=0.29 sa=0 sb=0 sd=0 mult=1
Vg_n g_n 0 0
Vd_n d_n 0 0
Vb_n b_n 0 0
Vg_p g_p 0 0
Vd_p d_p 0 0
Vb_p b_p 0 0
**** begin user architecture code

** opencircuitdesign pdks install
.lib /foss/pdks/sky130A/libs.tech/combined/sky130.lib.spice tt

* this option enables mos model bin
* selection based on W/NF instead of W

*FOR NMOS.
.control
alter Vd_n 0.05
dc Vg_n 0 1.8 0.005
let vgs = v(g_n)
let id = abs(i(Vd_n))
dc Vg_n 0.9 1.1 0.005
let x = v(g_n)
let y = abs(i(Vd_n))
let xm = mean(x)
let ym = mean(y)
let slope = mean((x-xm)*(y-ym))/mean((x-xm)*(x-xm))
let vgs0 = xm - ym/slope
let vth = vgs0 - 0.05/2
print slope vgs0 vth
let fit = slope*(dc1.vgs-vgs0)
let idmax = vecmax(dc1.id)
plot dc1.id fit vs dc1.vgs ylimit 0 $&idmax
.endc

**** end user architecture code
**.ends
.end
